* Switched-capacitor unit cell -- NGSPICE BSIM-CMG (LEVEL=72) GROUND TRUTH
* Benchmark 3d reference (docs/plans/2026-05-15-directnet-complex-circuits.md)
*
* Ground-truth topology for tests/verify_complex_switchcap.py. The harness
* regenerates a per-tech deck substituting <BAKED_LIB> / <VDD> / <NMOS> /
* <PMOS> / <VIN> (sampled DC level). OSDI devices use the N prefix; NGSPICE
* PULSE uses the parenthesised syntax.
*
* NEVER replace NGSPICE with a simplified/self-defined model
* (CLAUDE.md Validation rule).

.include "<BAKED_LIB>"
.temp 27

Vdd vdd 0 <VDD>
Vin vin 0 <VIN>
Vphi phi 0 PULSE(0 <VDD> 0.5n 0.1n 0.1n 1.9n 4n)

* --- clock inverter: phi -> phib ---
Npc phib phi vdd vdd <PMOS>
Nnc phib phi 0   0   <NMOS>

* --- CMOS transmission gate: vin <-> vsamp ---
Nnt vin phi  vsamp 0   <NMOS>
Npt vin phib vsamp vdd <PMOS>

Csample vsamp 0 100f

.ic v(vsamp)=0 v(phib)=<VDD>

* analysis statement supplied by the runner: tran 5p 12n uic

.end
