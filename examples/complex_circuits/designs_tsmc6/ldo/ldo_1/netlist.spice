* ldo_1 -- AnalogGym LDO on TSMC6 BSIM-CMG (LEVEL=72)
* Topology is the shipped one.  Geometry is re-designed for a 0.75 V
* rail, and the mim caps / poly resistors become ideal C and R because
* this TSMC6 view carries transistor models only.
.subckt ldo_1 Vss Vdd vinn vout vfb vinp Ib
NM8 vout net3 Vdd Vdd psvt_l60_f4 m=5082 $ pass device
NM1 net1 net1 Vdd Vdd psvt_l60_f10 m=4
NM0 net8 net1 Vdd Vdd psvt_l10_f4 m=2
NM6 net3 net8 Vdd Vdd psvt_l10_f2 m=1
NM7 net3 Ib Vss Vss nsvt_l36_f4 m=1
NM5 Ib Ib Vss Vss nsvt_l240_f20 m=45
NM4 net2 Ib Vss Vss nsvt_l240_f20 m=813
NM3 net8 vinp net2 Vss nsvt_l8_f6 m=15
NM2 net1 vinn net2 Vss nsvt_l10_f20 m=4
r0 vout vfb 100000
r1 vfb Vss 100000
Ccomp net3 ncomp 2.4e-11
Rcomp ncomp vout 15000
.ends ldo_1
