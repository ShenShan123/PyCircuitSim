* qu_lec_pin_3 -- AnalogGym topology on TSMC12 BSIM-CMG (LEVEL=72)
* Connectivity and mirror ratios are the shipped ones; geometry is re-designed for 0.8 V FinFET.
.subckt qu_lec_pin_3 gnda vdda vinn vinp vout
Nm60 net4 DM_1 net8 VDDA psvt_l128_f4 m=64   $ BIASCM_PMOS
Nm57 net8 net050 VDDA VDDA psvt_l110_f6 m=9   $ gma_PMOS
Nm2 DM_1 DM_1 VDDA VDDA psvt_l128_f4 m=4   $ BIASCM_PMOS
Nm62 net2 net3 VDDA VDDA psvt_l128_f4 m=16   $ BIASCM_PMOS
Nm68 VOUT net050 VDDA VDDA psvt_l110_f8 m=18   $ gmf_PMOS
Nm6 net050 VOUTN VDDA VDDA psvt_l128_f4 m=4   $ BIASCM_PMOS
Nm5 VOUTN VOUTN VDDA VDDA psvt_l128_f4 m=4   $ BIASCM_PMOS
Nm9 net063 VINP net31 net31 psvt_l110_f8 m=10   $ gm1_PMOS
Nm8 DM_2 VINN net31 net31 psvt_l110_f8 m=10   $ gm1_PMOS
Nm4 net31 net013 VDDA VDDA psvt_l128_f4 m=32   $ BIASCM_PMOS
Nm67 net5 VOUTN VDDA VDDA psvt_l128_f4 m=4   $ BIASCM_PMOS
Nm3 VB3 net013 VDDA VDDA psvt_l128_f4 m=16   $ BIASCM_PMOS
Nm1 VB4 net013 VDDA VDDA psvt_l128_f4 m=16   $ BIASCM_PMOS
Nm64 net3 net3 VDDA VDDA psvt_l128_f4 m=16   $ BIASCM_PMOS
Nm0 net013 net013 VDDA VDDA psvt_l128_f4 m=16   $ BIASCM_PMOS
Nm61 net4 VB4 GNDA GNDA nsvt_l128_f4 m=32   $ BIASCM_NMOS
Nm59 net4 net1 GNDA GNDA nsvt_l110_f6 m=9   $ gmb_NMOS
Nm19 DM_2 VB4 GNDA GNDA nsvt_l128_f4 m=32   $ BIASCM_NMOS
Nm15 VOUTN VB3 DM_2 GNDA nsvt_l128_f4 m=16   $ BIASCM_NMOS
Nm20 net063 VB4 GNDA GNDA nsvt_l128_f4 m=32   $ BIASCM_NMOS
Nm16 net050 VB3 net063 GNDA nsvt_l128_f4 m=16   $ BIASCM_NMOS
Nm18 net7 VB4 GNDA GNDA nsvt_l128_f4 m=16   $ BIASCM_NMOS
Nm63 net2 net2 GNDA GNDA nsvt_l110_f6 m=9   $ gmb_NMOS
Nm12 VB4 VB3 net6 GNDA nsvt_l128_f4 m=16   $ BIASCM_NMOS
Nm13 DM_1 VB3 net7 GNDA nsvt_l128_f4 m=16   $ BIASCM_NMOS
Nm17 net6 VB4 GNDA GNDA nsvt_l128_f4 m=16   $ BIASCM_NMOS
Nm69 VOUT net5 GNDA GNDA nsvt_l36_f12 m=16   $ gm3_NMOS
Nm66 net5 net4 GNDA GNDA nsvt_l110_f8 m=18   $ gm2_NMOS
Nm65 net3 net4 GNDA GNDA nsvt_l110_f6 m=9   $ gmb_NMOS
Nm14 VB3 VB3 GNDA GNDA nsvt_l128_f4 m=4   $ BIASCM_NMOS
I0 net013 GNDA 6.99932e-07
C1 net050 VOUT 1e-12
C0 net1 GNDA 2e-12
R0 net1 net2 20000
.ends qu_lec_pin_3
