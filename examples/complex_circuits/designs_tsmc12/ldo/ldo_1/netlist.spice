* ldo_1 -- AnalogGym LDO on TSMC12 BSIM-CMG (LEVEL=72)
* Topology is the shipped one.  Geometry is re-designed for a 0.8 V
* rail, and the mim caps / poly resistors become ideal C and R because
* this TSMC12 view carries transistor models only.
.subckt ldo_1 Vss Vdd vinn vout vfb vinp Ib
NM8 vout net3 Vdd Vdd psvt_l120_f6 m=3388 $ pass device
NM1 net1 net1 Vdd Vdd psvt_l60_f10 m=4
NM0 net8 net1 Vdd Vdd psvt_l20_f4 m=2
NM6 net3 net8 Vdd Vdd psvt_l36_f16 m=1
NM7 net3 Ib Vss Vss nsvt_l36_f2 m=2
NM5 Ib Ib Vss Vss nsvt_l180_f20 m=136
NM4 net2 Ib Vss Vss nsvt_l240_f10 m=271
NM3 net8 vinp net2 Vss nsvt_l16_f6 m=15
NM2 net1 vinn net2 Vss nsvt_l16_f20 m=4
r0 vout vfb 150000
r1 vfb Vss 150000
Ccomp net3 ncomp 1.2e-11
Rcomp ncomp vout 25000
.ends ldo_1
