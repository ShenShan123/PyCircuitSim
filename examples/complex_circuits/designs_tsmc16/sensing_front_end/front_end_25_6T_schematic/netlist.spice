* front_end_25_6T_schematic -- AnalogGym sensing front end on TSMC16 BSIM-CMG
* Topology is the shipped one; geometry is re-designed for 0.8 V.
.subckt front_end_25_6T_schematic GND VDD VOUT
NM5 VOUT VOUT GND GND nlnvt_l240_f3 m=1
NM4 net19 GND GND GND nlvt_l180_f3 m=691
NM3 net13 GND VOUT GND nulvt_l120_f20 m=432
NM2 net13 net13 GND GND nsvt_l240_f6 m=256
NM1 VDD GND net13 GND nulvt_l36_f20 m=12000
NM0 VDD GND net19 GND nhvt_l120_f10 m=617
.ends front_end_25_6T_schematic
