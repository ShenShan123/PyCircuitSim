* ldo_1 -- line regulation, max load on TSMC7 BSIM-CMG
* Measurement set is AnalogGym's TB_LDO_ACDC / TB_LDO_Tran.
.include ./tsmc7_models.spice
.include ./netlist.spice

.PARAM supply_voltage = 0.75
.PARAM Vref = 0.285645
.PARAM VOUT_NOM = 0.5625
V2 vss 0 0
Vindc vref_in 0 'Vref'
V1 vdd 0 'supply_voltage'
.nodeset V(vo)=0.5625
x1 0 vdd vref_in vo vo_fb vo_fb vo_ib ldo_1
I1_b vdd vo_ib 1.35417e-05
CL vo 0 1e-07
Iload vo 0 0.055
.end
