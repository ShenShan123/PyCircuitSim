* ldo_2 -- PSRR, max load on TSMC7 BSIM-CMG
* Measurement set is AnalogGym's TB_LDO_ACDC / TB_LDO_Tran.
.include ./tsmc7_models.spice
.include ./netlist.spice

.PARAM supply_voltage = 0.75
.PARAM Vref = 0.5625
.PARAM VOUT_NOM = 0.5625
V2 vss 0 0
Vindc vref_in 0 'Vref'
VVDDApsrr vddpsrr 0 'supply_voltage' AC=1
.nodeset V(vp)=0.5625
x2 0 vddpsrr vref_in vp vp_fb vp_fb vp_ib ldo_2
.nodeset V(x2.net42)=0.285 V(vp_ib)=0.3675
I2_b vddpsrr vp_ib 5e-06
CL2 vp 0 1e-07
Iload2 vp 0 0.055
.meas ac psrr_max find vdb(vp) at=0.1
.end
