* PLL_CHARGEPUMP -- AnalogGym charge pump on TSMC7 BSIM-CMG
* Only the block the transient bench reaches is ported; the rest
* of the shipped PLL is unreachable from this measurement.
.subckt PLL_QUENCH_v33 _net0 vin vout vref vss33
Npm11 vout vout net18 net18 psvt_l240_f2 m=5
Npm10 n79 vin net18 net18 psvt_l240_f2 m=5
Nnm1 vout n78 vss33 vss33 nsvt_l120_f4 m=1
Nnm0 n79 n78 vss33 vss33 nsvt_l240_f4 m=1
Npm12 _net0 vref _net0 _net0 psvt_l240_f6 m=25
Npm7 n78 vref _net0 _net0 psvt_l120_f4 m=2
Npm8 net18 vref _net0 _net0 psvt_l120_f4 m=2
Npm9 vss33 n79 n78 n78 psvt_l120_f4 m=32
.ends PLL_QUENCH_v33
.subckt PLL_CHARGEPUMP cp_out dn dnb i10u i5u pd pdb up upb _net0 vss33
Nnm31 i5u pd vss33 vss33 nsvt_l120_f6 m=7
Nnm30 nb2 pd vss33 vss33 nsvt_l120_f6 m=7
Npm29 pb1 pdb _net0 _net0 psvt_l60_f6 m=12
Npm22 pb2 pdb _net0 _net0 psvt_l60_f6 m=12
Npm11 net35 pb2 _net0 _net0 psvt_l120_f4 m=27
Npm12 net47 pb2 net79 _net0 psvt_l120_f4 m=27
Npm8 net98 pb1 net47 _net0 psvt_l120_f4 m=9
Npm10 pb2 pb1 net35 _net0 psvt_l120_f4 m=9
Npm3 net91 dnb cp_out net98 psvt_l120_f4 m=5
Npm1 net91 dn quench net98 psvt_l120_f4 m=5
Npm2 quench up net98 net98 psvt_l120_f4 m=5
Npm4 cp_out upb net98 net98 psvt_l120_f4 m=5
Nnm5 cp_out dn net91 vss33 nsvt_l120_f4 m=3
Nnm6 net98 up cp_out vss33 nsvt_l120_f4 m=3
Nnm7 quench dnb net91 vss33 nsvt_l120_f4 m=3
Nnm9 net98 upb quench vss33 nsvt_l120_f4 m=3
Nnm14 pb2 i5u net62 vss33 nsvt_l120_f4 m=2
Nnm18 net91 i5u net58 vss33 nsvt_l120_f4 m=2
Nnm21 pb1 i5u net0124 vss33 nsvt_l120_f4 m=2
Nnm23 net0153 i5u net0119 vss33 nsvt_l120_f4 m=2
Nnm15 net62 nb2 vss33 vss33 nsvt_l120_f4 m=2
Nnm17 net58 nb2 net78 vss33 nsvt_l120_f4 m=2
Nnm20 net0124 nb2 vss33 vss33 nsvt_l120_f4 m=2
Nnm24 net0119 net0153 vss33 vss33 nsvt_l120_f4 m=2
Nnm33 nb2 i10u net0149 vss33 nsvt_l60_f4 m=1
Nnm32 net0149 i10u net0153 vss33 nsvt_l60_f4 m=1
Nnm27 vss33 nb2 vss33 vss33 nsvt_l120_f4 m=3
Nnm13 i5u i5u vss33 vss33 nsvt_l120_f4 m=1
Nnm25 i10u i10u net0153 vss33 nsvt_l120_f4 m=2
Npm19 pb1 pb1 _net0 _net0 psvt_l120_f4 m=3
Nnm26 vss33 i5u vss33 vss33 nsvt_l120_f4 m=1
Npm28 _net0 pb2 _net0 _net0 psvt_l120_f4 m=1
Nnm34 vss33 _net0 vss33 vss33 nsvt_l120_f4 m=1
xi40 _net0 cp_out quench pb2 vss33 PLL_QUENCH_v33
vlower net78 vss33 DC=0
vupper _net0 net79 DC=0
.ends PLL_CHARGEPUMP
