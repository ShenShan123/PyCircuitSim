* ptat_4 -- AnalogGym sensing front end on TSMC5 BSIM-CMG
* Topology is the shipped one; geometry is re-designed for 0.65 V.
.subckt ptat_4 GND VDD VOUT
NM9 VDD VOUT VOUT GND nulvt_l68_f2 m=142
NM8 VDD VOUT VOUT GND nulvt_l101_f12 m=4000
NM7 VOUT VOUT GND GND nulvt_l101_f4 m=8
NM6 VOUT VOUT GND GND nulvt_l51_f6 m=1
NM3 VOUT VOUT GND GND nlvt_l51_f3 m=32
NM2 VDD VOUT VOUT GND nulvt_l34_f2 m=142
NM1 VOUT VOUT GND GND nlvt_l135_f2 m=12
NM0 VDD VOUT VOUT GND nsvt_l135_f2 m=3200
.ends ptat_4
