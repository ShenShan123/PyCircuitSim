* Basic_LDO -- AnalogGym LDO on TSMC5 BSIM-CMG (LEVEL=72)
* Topology is the shipped one.  Geometry is re-designed for a 0.65 V
* rail, and the mim caps / poly resistors become ideal C and R because
* this TSMC5 view carries transistor models only.
.subckt Basic_LDO gnda vdda vinn vout vfb vinp Ib
NM0 Ib Ib vdda vdda pulvt_l36_f4 m=3
NM1 vb4 Ib vdda vdda pulvt_l36_f4 m=3
NM2 dm_1 Ib vdda vdda pulvt_l36_f4 m=3
NM3 vb3 Ib vdda vdda pulvt_l36_f4 m=3
NM4 net20 Ib vdda vdda pulvt_l36_f4 m=7
NM5 voutn voutn vdda vdda pulvt_l36_f4 m=3
NM6 net10 voutn vdda vdda pulvt_l36_f4 m=3
NM7 net7 Ib vdda vdda pulvt_l36_f4 m=3
NM24 net1 Ib vdda vdda pulvt_l36_f4 m=3
NM11 vout net1 vdda vdda pulvt_l16_f12 m=99999 $ pass device
NM10 net12 net10 net1 net1 pulvt_l60_f4 m=864
NM8 dm_2 vinp net20 net20 pulvt_l90_f2 m=8
NM9 net106 vinn net20 net20 pulvt_l90_f2 m=8
NM14 vb3 vb3 gnda gnda nulvt_l120_f4 m=8
NM12 vb4 vb3 net28 gnda nulvt_l60_f4 m=8
NM13 dm_1 vb3 net31 gnda nulvt_l60_f4 m=8
NM15 voutn vb3 dm_2 gnda nulvt_l60_f4 m=8
NM16 net10 vb3 net106 gnda nulvt_l60_f4 m=8
NM17 net28 vb4 gnda gnda nulvt_l60_f4 m=8
NM18 net31 vb4 gnda gnda nulvt_l60_f4 m=8
NM19 dm_2 vb4 gnda gnda nulvt_l135_f3 m=16
NM20 net106 vb4 gnda gnda nulvt_l135_f3 m=16
NM21 net12 net7 gnda gnda nulvt_l36_f2 m=9840
NM22 net7 net7 gnda gnda nulvt_l36_f2 m=9840
r1 vout vfb 36124
r0 vfb gnda 36124
CC0 net106 vout 1.6e-11   $ was XC0 (mim)
.ends Basic_LDO
