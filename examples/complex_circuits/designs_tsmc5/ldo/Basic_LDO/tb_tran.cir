* Basic_LDO -- load-step transient on TSMC5 BSIM-CMG
* Measurement set is AnalogGym's TB_LDO_ACDC / TB_LDO_Tran.
.include ./tsmc5_models.spice
.include ./netlist.spice

.PARAM supply_voltage = 0.65
.PARAM Vref = 0.24375
.PARAM VOUT_NOM = 0.4875
V2 vss 0 0
Vindc vref_in 0 'Vref'
V1 vdd 0 'supply_voltage'
.nodeset V(vo)=0.4875
x1 0 vdd vref_in vo vo_fb vo_fb vo_ib Basic_LDO
I1_b vo_ib 0 2e-05
CL vo 0 1e-07
.option cshunt=1e-15
.option method=gear
Iload vo 0 pulse(0.005 0.055 2u 100n 100n 20u 60u)
.meas tran v_pre AVG v(vo) from=1u to=1.9u
.meas tran v_min MIN v(vo) from=2u to=22u
.meas tran v_max MAX v(vo) from=22u to=42u
.meas tran undershoot param='v_pre-v_min'
.meas tran overshoot param='max(0,v_max-v_pre)'
.end
