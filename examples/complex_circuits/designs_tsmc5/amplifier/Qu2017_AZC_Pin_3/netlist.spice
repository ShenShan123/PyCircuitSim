* qu2017_azc_pin_3 -- AnalogGym topology on TSMC5 BSIM-CMG (LEVEL=72)
* Connectivity and mirror ratios are the shipped ones; geometry is re-designed for 0.65 V FinFET.
.subckt qu2017_azc_pin_3 gnda vdda vinn vinp vout
Nm7 net057 net055 VDDA VDDA psvt_l62_f8 m=108   $ AZC2_PMOS
Nm6 net055 net055 VDDA VDDA psvt_l62_f8 m=54   $ AZC2_PMOS
Nm3 net078 VB1 VDDA VDDA psvt_l84_f2 m=18   $ BIASCM_PMOS
Nm13 VOUT net050 VDDA VDDA psvt_l135_f6 m=3   $ gmf2_PMOS
Nm8 net049 VB1 VDDA VDDA psvt_l84_f2 m=6   $ BIASCM_PMOS
Nm11 net094 net050 VDDA VDDA psvt_l31_f8 m=8   $ gm2_PMOS
Nm5 net050 VOUTN VDDA VDDA psvt_l84_f2 m=3   $ BIASCM_PMOS
Nm4 VOUTN VOUTN VDDA VDDA psvt_l84_f2 m=3   $ BIASCM_PMOS
Nm10 net063 VINP net019 net019 psvt_l80_f12 m=3   $ gm1_PMOS
Nm9 DM_2 VINN net019 net019 psvt_l80_f12 m=3   $ gm1_PMOS
Nm2 net019 VB1 VDDA VDDA psvt_l84_f2 m=6   $ BIASCM_PMOS
Nm1 VB4 VB1 VDDA VDDA psvt_l84_f2 m=3   $ BIASCM_PMOS
Nm0 VB1 VB1 VDDA VDDA psvt_l84_f2 m=3   $ BIASCM_PMOS
Nm24 net049 net057 GNDA GNDA nsvt_l38_f5 m=9   $ AZC3_NMOS
Nm12 net055 net094 GNDA GNDA nsvt_l38_f12 m=486   $ AZC1_NMOS
Nm16 net077 DM_2 GNDA GNDA nsvt_l135_f1 m=1   $ LOAD1_NMOS
Nm17 net082 net063 GNDA GNDA nsvt_l135_f1 m=1   $ LOAD1_NMOS
Nm18 VOUT net049 GNDA GNDA nsvt_l135_f5 m=2   $ gm3_NMOS
Nm22 net094 net051 GNDA GNDA nsvt_l38_f5 m=36   $ AZC3_NMOS
Nm23 net057 net043 GNDA GNDA nsvt_l38_f5 m=27   $ AZC3_NMOS
Nm20 DM_2 VB4 GNDA GNDA nsvt_l83_f2 m=3   $ BIASCM_NMOS
Nm14 VOUTN net077 DM_2 GNDA nsvt_l135_f1 m=1   $ LOAD1_NMOS
Nm21 net063 VB4 GNDA GNDA nsvt_l83_f2 m=3   $ BIASCM_NMOS
Nm15 net050 net082 net063 GNDA nsvt_l135_f1 m=1   $ LOAD1_NMOS
Nm19 VB4 VB4 GNDA GNDA nsvt_l83_f2 m=3   $ BIASCM_NMOS
I0 VB1 GNDA 1.05785e-06
C2 net043 GNDA 4e-13
C1 net051 GNDA 4e-13
C0 net063 VOUT 2e-12
R3 net057 net043 8000
R2 net057 net051 781250
R1 net078 net082 8000
R0 net078 net077 50000
.ends qu2017_azc_pin_3
