* front_end_25_6T_schematic -- AnalogGym sensing front end on TSMC12 BSIM-CMG
* Topology is the shipped one; geometry is re-designed for 0.8 V.
.subckt front_end_25_6T_schematic GND VDD VOUT
NM5 VOUT VOUT GND GND nsvt_l240_f2 m=1
NM4 net19 GND GND GND nulvt_l36_f2 m=4
NM3 net13 GND VOUT GND nulvt_l120_f10 m=240
NM2 net13 net13 GND GND nulvt_l180_f4 m=30
NM1 VDD GND net13 GND nulvt_l36_f20 m=4000
NM0 VDD GND net19 GND nsvt_l120_f10 m=27
.ends front_end_25_6T_schematic
