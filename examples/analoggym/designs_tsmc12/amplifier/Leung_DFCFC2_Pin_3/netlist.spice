* leung_dfcfc2_pin_3 -- AnalogGym topology on TSMC12 BSIM-CMG (LEVEL=72)
* Connectivity and mirror ratios are the shipped ones; geometry is re-designed for 0.8 V FinFET.
.subckt leung_dfcfc2_pin_3 gnda vdda vinn vinp vout
Nm12 VOUT net050 VDDA VDDA psvt_l36_f6 m=7   $ gmf2_PMOS
Nm7 net049 net1 VDDA VDDA psvt_l240_f7 m=3   $ BIASCM_PMOS
Nm11 net043 net050 VDDA VDDA psvt_l60_f8 m=18   $ gm2_PMOS
Nm10 net2 net050 VDDA VDDA psvt_l240_f1 m=1   $ gm4_PMOS
Nm6 net050 VOUTN VDDA VDDA psvt_l240_f7 m=3   $ BIASCM_PMOS
Nm5 VOUTN VOUTN VDDA VDDA psvt_l240_f7 m=3   $ BIASCM_PMOS
Nm9 net063 VINP net31 net31 psvt_l96_f10 m=2   $ gm1_PMOS
Nm8 DM_2 VINN net31 net31 psvt_l96_f10 m=2   $ gm1_PMOS
Nm4 net31 net1 VDDA VDDA psvt_l240_f7 m=6   $ BIASCM_PMOS
Nm3 VB3 net1 VDDA VDDA psvt_l240_f7 m=3   $ BIASCM_PMOS
Nm2 DM_1 net1 VDDA VDDA psvt_l240_f7 m=3   $ BIASCM_PMOS
Nm1 VB4 net1 VDDA VDDA psvt_l240_f7 m=3   $ BIASCM_PMOS
Nm0 net1 net1 VDDA VDDA psvt_l240_f7 m=3   $ BIASCM_PMOS
Nm25 VOUT net049 GNDA GNDA nsvt_l149_f4 m=11   $ gm3_NMOS
Nm24 net049 net043 GNDA GNDA nsvt_l38_f6 m=54   $ LOAD2_NMOS
Nm23 net043 net043 GNDA GNDA nsvt_l38_f6 m=54   $ LOAD2_NMOS
Nm20 DM_2 VB4 GNDA GNDA nsvt_l150_f1 m=128   $ BIASCM_NMOS
Nm16 VOUTN VB3 DM_2 GNDA nsvt_l150_f1 m=64   $ BIASCM_NMOS
Nm21 net063 VB4 GNDA GNDA nsvt_l150_f1 m=128   $ BIASCM_NMOS
Nm17 net050 VB3 net063 GNDA nsvt_l150_f1 m=64   $ BIASCM_NMOS
Nm18 net54 VB4 GNDA GNDA nsvt_l150_f1 m=64   $ BIASCM_NMOS
Nm22 net2 VB4 GNDA GNDA nsvt_l150_f1 m=64   $ BIASCM_NMOS
Nm15 VB3 VB3 GNDA GNDA nsvt_l150_f1 m=16   $ BIASCM_NMOS
Nm13 VB4 VB3 net54 GNDA nsvt_l150_f1 m=64   $ BIASCM_NMOS
Nm19 net56 VB4 GNDA GNDA nsvt_l150_f1 m=64   $ BIASCM_NMOS
Nm14 DM_1 VB3 net56 GNDA nsvt_l150_f1 m=64   $ BIASCM_NMOS
I0 net1 GNDA 8e-06
C1 net050 VOUT 4e-12
C2 net050 net2 5e-13
.ends leung_dfcfc2_pin_3
