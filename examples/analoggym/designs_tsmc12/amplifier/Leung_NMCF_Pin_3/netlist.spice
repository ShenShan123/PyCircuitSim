* leung_nmcf_pin_3 -- AnalogGym topology on TSMC12 BSIM-CMG (LEVEL=72)
* Connectivity and mirror ratios are the shipped ones; geometry is re-designed for 0.8 V FinFET.
.subckt leung_nmcf_pin_3 gnda vdda vinn vinp vout
Nm11 VOUT net050 VDDA VDDA psvt_l16_f10 m=16   $ gmf2_PMOS
Nm7 net049 net013 VDDA VDDA psvt_l240_f1 m=8   $ BIASCM_PMOS
Nm10 net043 net050 VDDA VDDA psvt_l100_f8 m=72   $ gm2_PMOS
Nm6 net050 VOUTN VDDA VDDA psvt_l240_f1 m=8   $ BIASCM_PMOS
Nm5 VOUTN VOUTN VDDA VDDA psvt_l240_f1 m=8   $ BIASCM_PMOS
Nm9 net063 VINP net31 net31 psvt_l184_f8 m=2   $ gm1_PMOS
Nm8 DM_2 VINN net31 net31 psvt_l184_f8 m=2   $ gm1_PMOS
Nm4 net31 net013 VDDA VDDA psvt_l240_f1 m=32   $ BIASCM_PMOS
Nm3 VB3 net013 VDDA VDDA psvt_l240_f1 m=8   $ BIASCM_PMOS
Nm2 DM_1 net013 VDDA VDDA psvt_l240_f1 m=8   $ BIASCM_PMOS
Nm1 VB4 net013 VDDA VDDA psvt_l240_f1 m=8   $ BIASCM_PMOS
Nm0 net013 net013 VDDA VDDA psvt_l240_f1 m=8   $ BIASCM_PMOS
Nm14 VB3 VB3 GNDA GNDA nsvt_l240_f1 m=18   $ BIASCM_NMOS
Nm23 VOUT net049 GNDA GNDA nsvt_l35_f4 m=8   $ gm3_NMOS
Nm22 net049 net043 GNDA GNDA nsvt_l24_f10 m=240   $ LOAD2_NMOS
Nm21 net043 net043 GNDA GNDA nsvt_l24_f10 m=240   $ LOAD2_NMOS
Nm19 DM_2 VB4 GNDA GNDA nsvt_l240_f1 m=144   $ BIASCM_NMOS
Nm15 VOUTN VB3 DM_2 GNDA nsvt_l240_f1 m=72   $ BIASCM_NMOS
Nm20 net063 VB4 GNDA GNDA nsvt_l240_f1 m=144   $ BIASCM_NMOS
Nm16 net050 VB3 net063 GNDA nsvt_l240_f1 m=72   $ BIASCM_NMOS
Nm17 net54 VB4 GNDA GNDA nsvt_l240_f1 m=72   $ BIASCM_NMOS
Nm12 VB4 VB3 net54 GNDA nsvt_l240_f1 m=72   $ BIASCM_NMOS
Nm18 net56 VB4 GNDA GNDA nsvt_l240_f1 m=72   $ BIASCM_NMOS
Nm13 DM_1 VB3 net56 GNDA nsvt_l240_f1 m=72   $ BIASCM_NMOS
I0 net013 GNDA 8.35918e-07
C1 net049 VOUT 1.5625e-12
C0 net050 VOUT 1.25e-11
.ends leung_nmcf_pin_3
