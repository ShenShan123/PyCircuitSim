* peng_acbc_pin_3 -- AnalogGym topology on TSMC12 BSIM-CMG (LEVEL=72)
* Connectivity and mirror ratios are the shipped ones; geometry is re-designed for 0.8 V FinFET.
.subckt peng_acbc_pin_3 gnda vdda vinn vinp vout
Nm59 net1 net1 VDDA VDDA psvt_l60_f1 m=1   $ ma1_PMOS
Nm12 VOUT net050 VDDA VDDA psvt_l41_f6 m=3   $ gmf2_PMOS
Nm7 net049 net013 VDDA VDDA psvt_l240_f1 m=1   $ BIASCM_PMOS
Nm11 net043 net050 VDDA VDDA psvt_l120_f20 m=1   $ gm2_PMOS
Nm6 net050 VOUTN VDDA VDDA psvt_l240_f1 m=1   $ BIASCM_PMOS
Nm5 VOUTN VOUTN VDDA VDDA psvt_l240_f1 m=1   $ BIASCM_PMOS
Nm10 net063 VINP net31 net31 psvt_l240_f1 m=1   $ gm1_PMOS
Nm9 DM_2 VINN net31 net31 psvt_l240_f1 m=1   $ gm1_PMOS
Nm4 net31 net013 VDDA VDDA psvt_l240_f1 m=2   $ BIASCM_PMOS
Nm3 VB3 net013 VDDA VDDA psvt_l240_f1 m=1   $ BIASCM_PMOS
Nm2 DM_1 net013 VDDA VDDA psvt_l240_f1 m=1   $ BIASCM_PMOS
Nm8 net1 net013 VDDA VDDA psvt_l240_f1 m=1   $ BIASCM_PMOS
Nm1 VB4 net013 VDDA VDDA psvt_l240_f1 m=1   $ BIASCM_PMOS
Nm0 net013 net013 VDDA VDDA psvt_l240_f1 m=1   $ BIASCM_PMOS
Nm25 VOUT net049 GNDA GNDA nsvt_l106_f3 m=1   $ gm3_NMOS
Nm23 net049 net043 GNDA GNDA nsvt_l105_f4 m=8   $ LOAD2_NMOS
Nm22 net043 net043 GNDA GNDA nsvt_l105_f4 m=8   $ LOAD2_NMOS
Nm20 DM_2 VB4 GNDA GNDA nsvt_l240_f1 m=8   $ BIASCM_NMOS
Nm16 VOUTN VB3 DM_2 GNDA nsvt_l240_f1 m=4   $ BIASCM_NMOS
Nm21 net063 VB4 GNDA GNDA nsvt_l240_f1 m=8   $ BIASCM_NMOS
Nm17 net050 VB3 net063 GNDA nsvt_l240_f1 m=4   $ BIASCM_NMOS
Nm18 net54 VB4 GNDA GNDA nsvt_l240_f1 m=4   $ BIASCM_NMOS
Nm24 net1 net043 GNDA GNDA nsvt_l60_f3 m=4   $ gm4_NMOS
Nm15 VB3 VB3 GNDA GNDA nsvt_l240_f1 m=1   $ BIASCM_NMOS
Nm13 VB4 VB3 net54 GNDA nsvt_l240_f1 m=4   $ BIASCM_NMOS
Nm19 net56 VB4 GNDA GNDA nsvt_l240_f1 m=4   $ BIASCM_NMOS
Nm14 DM_1 VB3 net56 GNDA nsvt_l240_f1 m=4   $ BIASCM_NMOS
I0 net013 GNDA 1.29574e-07
C1 net049 net1 2e-12
C0 net050 VOUT 5e-13
.ends peng_acbc_pin_3
