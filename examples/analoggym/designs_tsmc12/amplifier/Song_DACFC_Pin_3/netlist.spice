* song_dacfc_pin_3 -- AnalogGym topology on TSMC12 BSIM-CMG (LEVEL=72)
* Connectivity and mirror ratios are the shipped ones; geometry is re-designed for 0.8 V FinFET.
.subckt song_dacfc_pin_3 gnda vdda vinn vinp vout
Nm69 net3 net70 VDDA VDDA psvt_l240_f4 m=12   $ BIASCM_PMOS
Nm68 net2 net70 VDDA VDDA psvt_l240_f4 m=12   $ BIASCM_PMOS
Nm63 net70 DM_1 net2 VDDA psvt_l240_f4 m=12   $ BIASCM_PMOS
Nm62 VOUTN DM_1 net3 VDDA psvt_l240_f4 m=12   $ BIASCM_PMOS
Nm61 net4 DM_1 net050 VDDA psvt_l240_f4 m=12   $ BIASCM_PMOS
Nm60 VOUTN DM_1 net5 VDDA psvt_l240_f4 m=12   $ BIASCM_PMOS
Nm59 net1 net013 VDDA VDDA psvt_l240_f4 m=6   $ BIASCM_PMOS
Nm58 net049 VINP net1 net1 psvt_l60_f8 m=24   $ gmf1_PMOS
Nm57 net043 VINN net1 net1 psvt_l60_f8 m=24   $ gmf1_PMOS
Nm11 VOUT net4 VDDA VDDA psvt_l76_f10 m=3   $ gmf2_PMOS
Nm7 net049 VOUTN VDDA VDDA psvt_l60_f6 m=12   $ gma2_PMOS
Nm10 net043 net4 VDDA VDDA psvt_l60_f8 m=24   $ gm2_PMOS
Nm6 net050 VOUTN VDDA VDDA psvt_l60_f6 m=12   $ gma1_PMOS
Nm5 net5 VOUTN VDDA VDDA psvt_l60_f6 m=12   $ gma1_PMOS
Nm9 net063 VINP net31 net31 psvt_l60_f8 m=40   $ gm1_PMOS
Nm8 DM_2 VINN net31 net31 psvt_l60_f8 m=40   $ gm1_PMOS
Nm4 net31 net013 VDDA VDDA psvt_l240_f4 m=6   $ BIASCM_PMOS
Nm3 VB3 net013 VDDA VDDA psvt_l240_f4 m=12   $ BIASCM_PMOS
Nm2 DM_1 DM_1 VDDA VDDA psvt_l240_f4 m=3   $ BIASCM_PMOS
Nm1 VB4 net013 VDDA VDDA psvt_l240_f4 m=12   $ BIASCM_PMOS
Nm0 net013 net013 VDDA VDDA psvt_l240_f4 m=12   $ BIASCM_PMOS
Nm71 VOUTN VB3 net85 GNDA nsvt_l240_f4 m=12   $ BIASCM_NMOS
Nm70 net70 VB3 net69 GNDA nsvt_l240_f4 m=12   $ BIASCM_NMOS
Nm65 net69 VB4 GNDA GNDA nsvt_l240_f4 m=24   $ BIASCM_NMOS
Nm64 net85 VB4 GNDA GNDA nsvt_l240_f4 m=24   $ BIASCM_NMOS
Nm23 VOUT net049 GNDA GNDA nsvt_l76_f12 m=6   $ gm3_NMOS
Nm22 net049 net043 GNDA GNDA nsvt_l240_f4 m=3   $ LOAD2_NMOS
Nm21 net043 net043 GNDA GNDA nsvt_l240_f4 m=3   $ LOAD2_NMOS
Nm19 DM_2 VB4 GNDA GNDA nsvt_l240_f4 m=24   $ BIASCM_NMOS
Nm15 VOUTN VB3 DM_2 GNDA nsvt_l240_f4 m=12   $ BIASCM_NMOS
Nm20 net063 VB4 GNDA GNDA nsvt_l240_f4 m=24   $ BIASCM_NMOS
Nm16 net4 VB3 net063 GNDA nsvt_l240_f4 m=12   $ BIASCM_NMOS
Nm17 net54 VB4 GNDA GNDA nsvt_l240_f4 m=12   $ BIASCM_NMOS
Nm14 VB3 VB3 GNDA GNDA nsvt_l240_f4 m=3   $ BIASCM_NMOS
Nm12 VB4 VB3 net54 GNDA nsvt_l240_f4 m=12   $ BIASCM_NMOS
Nm18 net56 VB4 GNDA GNDA nsvt_l240_f4 m=12   $ BIASCM_NMOS
Nm13 DM_1 VB3 net56 GNDA nsvt_l240_f4 m=12   $ BIASCM_NMOS
I0 net013 GNDA 1.69626e-06
C2 net4 GNDA 1e-12
C0 VOUT net70 2e-12
.ends song_dacfc_pin_3
