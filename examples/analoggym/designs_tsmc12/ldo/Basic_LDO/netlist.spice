* Basic_LDO -- AnalogGym LDO on TSMC12 BSIM-CMG (LEVEL=72)
* Topology is the shipped one.  Geometry is re-designed for a 0.8 V
* rail, and the mim caps / poly resistors become ideal C and R because
* this TSMC12 view carries transistor models only.
.subckt Basic_LDO gnda vdda vinn vout vfb vinp Ib
NM0 Ib Ib vdda vdda psvt_l36_f6 m=3
NM1 vb4 Ib vdda vdda psvt_l36_f6 m=3
NM2 dm_1 Ib vdda vdda psvt_l36_f6 m=3
NM3 vb3 Ib vdda vdda psvt_l36_f6 m=3
NM4 net20 Ib vdda vdda psvt_l16_f4 m=7
NM5 voutn voutn vdda vdda psvt_l36_f6 m=3
NM6 net10 voutn vdda vdda psvt_l36_f6 m=3
NM7 net7 Ib vdda vdda psvt_l36_f6 m=3
NM24 net1 Ib vdda vdda psvt_l36_f6 m=3
NM11 vout net1 vdda vdda pulvt_l16_f16 m=33333 $ pass device
NM10 net12 net10 net1 net1 psvt_l60_f4 m=216
NM8 dm_2 vinp net20 net20 psvt_l90_f2 m=8
NM9 net106 vinn net20 net20 psvt_l90_f2 m=8
NM14 vb3 vb3 gnda gnda nsvt_l120_f4 m=8
NM12 vb4 vb3 net28 gnda nsvt_l36_f4 m=8
NM13 dm_1 vb3 net31 gnda nsvt_l36_f4 m=8
NM15 voutn vb3 dm_2 gnda nsvt_l36_f4 m=8
NM16 net10 vb3 net106 gnda nsvt_l36_f4 m=8
NM17 net28 vb4 gnda gnda nsvt_l36_f4 m=8
NM18 net31 vb4 gnda gnda nsvt_l36_f4 m=8
NM19 dm_2 vb4 gnda gnda nsvt_l180_f3 m=16
NM20 net106 vb4 gnda gnda nsvt_l180_f3 m=16
NM21 net12 net7 gnda gnda nsvt_l16_f2 m=9840
NM22 net7 net7 gnda gnda nsvt_l16_f2 m=9840
r1 vout vfb 1083.72
r0 vfb gnda 1083.72
CC0 net106 vout 8e-12   $ was XC0 (mim)
.ends Basic_LDO
