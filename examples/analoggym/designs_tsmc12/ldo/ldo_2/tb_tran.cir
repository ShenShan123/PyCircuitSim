* ldo_2 -- load-step transient on TSMC12 BSIM-CMG
* Measurement set is AnalogGym's TB_LDO_ACDC / TB_LDO_Tran.
.include ./tsmc12_models.spice
.include ./netlist.spice

.PARAM supply_voltage = 0.8
.PARAM Vref = 0.6
.PARAM VOUT_NOM = 0.6
V2 vss 0 0
Vindc vref_in 0 'Vref'
V1 vdd 0 'supply_voltage'
.nodeset V(vo)=0.6
x1 0 vdd vref_in vo vo_fb vo_fb vo_ib ldo_2
.nodeset V(x1.net42)=0.304 V(vo_ib)=0.392
I1_b vdd vo_ib 5e-06
CL vo 0 1e-07
.option cshunt=1e-15
.option method=gear
.nodeset V(x1.net42)=0.304 V(vo_ib)=0.392
Iload vo 0 pulse(0.005 0.055 2u 100n 100n 20u 60u)
.meas tran v_pre AVG v(vo) from=1u to=1.9u
.meas tran v_min MIN v(vo) from=2u to=22u
.meas tran v_max MAX v(vo) from=22u to=42u
.meas tran undershoot param='v_pre-v_min'
.meas tran overshoot param='max(0,v_max-v_pre)'
.end
