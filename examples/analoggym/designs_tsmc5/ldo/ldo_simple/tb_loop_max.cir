* ldo_simple -- loop response, max load on TSMC5 BSIM-CMG
* Measurement set is AnalogGym's TB_LDO_ACDC / TB_LDO_Tran.
.include ./tsmc5_models.spice
.include ./netlist.spice

.PARAM supply_voltage = 0.65
.PARAM Vref = 0.4875
.PARAM VOUT_NOM = 0.4875
V2 vss 0 0
Vindc vref_in 0 'Vref'
V1 vdd 0 'supply_voltage'
.nodeset V(vo)=0.4875
x1 vdd vo_inp vref_in vo_vb 0 vo ldo_simple
V1_vb vo_vb 0 0.325
CL vo 0 1e-07
Iload vo 0 0.055
Vin signal_in 0 dc 'Vref' ac 1
Lfb vo_inp vo 1T
Cfb vo_inp signal_in 1T
.meas ac dcgain_max find vdb(vo) at=0.1
.meas ac gbw_max when vdb(vo)=0
.meas ac ph_rad_max find vp(vo) when vdb(vo)=0
.meas ac pm_max param='abs(ph_rad_max)*180/3.1416'
.end
