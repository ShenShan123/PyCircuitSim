* ldo_simple -- AnalogGym LDO on TSMC5 BSIM-CMG (LEVEL=72)
* Topology is the shipped one.  Geometry is re-designed for a 0.65 V
* rail, and the mim caps / poly resistors become ideal C and R because
* this TSMC5 view carries transistor models only.
.subckt ldo_simple Vdd vinp vinn Vb Vss Vreg
NM1 net1 vinp net2 Vss nsvt_l68_f4 m=16
NM2 vout1 vinn net2 Vss nsvt_l135_f6 m=2
NM3 vout1 net1 Vdd Vdd psvt_l101_f2 m=8
NM4 net1 net1 Vdd Vdd psvt_l135_f6 m=8
NM5 net2 Vb Vss Vss nsvt_l68_f2 m=72
NM6 Vreg vout1 Vdd Vdd psvt_l34_f12 m=12000 $ pass device
CCfb net22 Vreg 5.49316e-12   $ was XCfb (mim)
RRfb net22 vout1 125000   $ was XRfb (poly)
.ends ldo_simple
