* ldo_folded_cascode -- line regulation, min load on TSMC5 BSIM-CMG
* Measurement set is AnalogGym's TB_LDO_ACDC / TB_LDO_Tran.
.include ./tsmc5_models.spice
.include ./netlist.spice

.PARAM supply_voltage = 0.65
.PARAM Vref = 0.491563
.PARAM VOUT_NOM = 0.4875
V2 vss 0 0
Vindc vref_in 0 'Vref'
V1 vdd 0 'supply_voltage'
.nodeset V(vo)=0.4875
x1 vdd vo vo_vb2 vref_in vo_vb1 0 vo ldo_folded_cascode
V1_vb2 vo_vb2 0 0.0333333
V1_vb1 vo_vb1 0 0.4
CL vo 0 1e-07
Iload vo 0 0.005
.end
