* front_end_25_6T_schematic -- AnalogGym sensing front end on TSMC5 BSIM-CMG
* Topology is the shipped one; geometry is re-designed for 0.65 V.
.subckt front_end_25_6T_schematic GND VDD VOUT
NM5 VOUT VOUT GND GND nsvt_l135_f3 m=1
NM4 net19 GND GND GND nulvt_l34_f2 m=4
NM3 net13 GND VOUT GND nulvt_l135_f2 m=360
NM2 net13 net13 GND GND nulvt_l135_f2 m=3
NM1 VDD GND net13 GND nulvt_l20_f12 m=1728
NM0 VDD GND net19 GND nsvt_l135_f10 m=27
.ends front_end_25_6T_schematic
