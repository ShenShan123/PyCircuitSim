* PTAT_CLASSIC -- AnalogGym sensing front end on TSMC5 BSIM-CMG
* Topology is the shipped one; geometry is re-designed for 0.65 V.
.subckt PTAT_CLASSIC VDDA vsense GNDA
Nm0 vsense net1 net12 net12 nulvt_l101_f10 m=16
Nm1 net1 net1 gnda gnda nulvt_l101_f3 m=4
Nm3 vsense vsense VDDA VDDA pulvt_l68_f2 m=64
Nm4 net1 vsense VDDA VDDA pulvt_l135_f10 m=32
r0 net12 gnda 1000
.ends PTAT_CLASSIC
