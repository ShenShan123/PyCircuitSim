* dual_output_subthreshold_vref -- AnalogGym voltage reference temperature bench on TSMC5
* Measurement set is the shipped one; TC is in ppm/C.
.include ./tsmc5_models.spice
.include ./netlist.spice

* These references run on picoamp sub-threshold currents; ngspice's
* default 1 pA ABSTOL is larger than the currents themselves, and the
* temperature sweep aborts before it reaches 25 C.
.options abstol=1e-16 gmin=1e-15 reltol=1e-4
.nodeset V(vref1)=0.24375 V(vref2)=0.24375

.PARAM supply_voltage = 0.65
Vvdda vdda 0 'supply_voltage'

.measure dc vref1_at25 FIND v(vref1) AT=25
.measure dc vref1_max  MAX  v(vref1) from=-40 to=125
.measure dc vref1_min  MIN  v(vref1) from=-40 to=125
.measure dc vref1_pp   PP   v(vref1) from=-40 to=125
.measure dc vref1_avg  AVG  v(vref1) from=-40 to=125
.measure dc vref1_tc   param='vref1_pp/vref1_avg/165*1e6'
.measure dc vref2_at25 FIND v(vref2) AT=25
.measure dc vref2_max  MAX  v(vref2) from=-40 to=125
.measure dc vref2_min  MIN  v(vref2) from=-40 to=125
.measure dc vref2_pp   PP   v(vref2) from=-40 to=125
.measure dc vref2_avg  AVG  v(vref2) from=-40 to=125
.measure dc vref2_tc   param='vref2_pp/vref2_avg/165*1e6'
.end
