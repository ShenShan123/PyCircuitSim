* leung_nmcnr_pin_3 -- AnalogGym topology on TSMC5 BSIM-CMG (LEVEL=72)
* Connectivity and mirror ratios are the shipped ones; geometry is re-designed for 0.65 V FinFET.
.subckt leung_nmcnr_pin_3 gnda vdda vinn vinp vout
Nm11 VOUT net013 VDDA VDDA psvt_l68_f4 m=10   $ BIASCM_PMOS
Nm7 net049 net013 VDDA VDDA psvt_l68_f4 m=1   $ BIASCM_PMOS
Nm10 net043 net050 VDDA VDDA psvt_l109_f5 m=1   $ gm2_PMOS
Nm6 net050 VOUTN VDDA VDDA psvt_l68_f4 m=1   $ BIASCM_PMOS
Nm5 VOUTN VOUTN VDDA VDDA psvt_l68_f4 m=1   $ BIASCM_PMOS
Nm9 net063 VINP net31 net31 psvt_l68_f3 m=6   $ gm1_PMOS
Nm8 DM_2 VINN net31 net31 psvt_l68_f3 m=6   $ gm1_PMOS
Nm4 net31 net013 VDDA VDDA psvt_l68_f4 m=4   $ BIASCM_PMOS
Nm3 VB3 net013 VDDA VDDA psvt_l68_f4 m=1   $ BIASCM_PMOS
Nm2 DM_1 net013 VDDA VDDA psvt_l68_f4 m=1   $ BIASCM_PMOS
Nm1 VB4 net013 VDDA VDDA psvt_l68_f4 m=1   $ BIASCM_PMOS
Nm0 net013 net013 VDDA VDDA psvt_l68_f4 m=1   $ BIASCM_PMOS
Nm23 VOUT net049 GNDA GNDA nsvt_l26_f1 m=4   $ gm3_NMOS
Nm22 net049 net043 GNDA GNDA nsvt_l18_f5 m=9   $ LOAD2_NMOS
Nm21 net043 net043 GNDA GNDA nsvt_l18_f5 m=9   $ LOAD2_NMOS
Nm19 DM_2 VB4 GNDA GNDA nsvt_l43_f10 m=24   $ BIASCM_NMOS
Nm15 VOUTN VB3 DM_2 GNDA nsvt_l43_f10 m=12   $ BIASCM_NMOS
Nm20 net063 VB4 GNDA GNDA nsvt_l43_f10 m=24   $ BIASCM_NMOS
Nm16 net050 VB3 net063 GNDA nsvt_l43_f10 m=12   $ BIASCM_NMOS
Nm17 net54 VB4 GNDA GNDA nsvt_l43_f10 m=12   $ BIASCM_NMOS
Nm14 VB3 VB3 GNDA GNDA nsvt_l43_f10 m=3   $ BIASCM_NMOS
Nm12 VB4 VB3 net54 GNDA nsvt_l43_f10 m=12   $ BIASCM_NMOS
Nm18 net56 VB4 GNDA GNDA nsvt_l43_f10 m=12   $ BIASCM_NMOS
Nm13 DM_1 VB3 net56 GNDA nsvt_l43_f10 m=12   $ BIASCM_NMOS
I0 net013 GNDA 8.92857e-07
C1 net044 net049 8e-13
C0 net050 net044 8e-12
R0 net044 VOUT 8000
.ends leung_nmcnr_pin_3
