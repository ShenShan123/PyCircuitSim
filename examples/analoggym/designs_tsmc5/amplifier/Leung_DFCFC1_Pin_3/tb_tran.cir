* leung_dfcfc1_pin_3 -- slew-rate bench on TSMC5 BSIM-CMG
* Measurements are AnalogGym's TB_Amplifier_Tran.cir verbatim; supply, common
* mode and load are the TSMC5 design point.
*
* AnalogGym runs all five amplifier instances from one deck.  They share only
* ideal supply rails, so they are electrically independent and splitting them
* changes no measurement -- but five 90 dB loops in one matrix does not solve:
* gmin, source stepping and the transient op all fail, and which groupings
* happen to converge is luck of the Newton basin, not a rule.  One instance per
* deck is the only robust structure.
.include ./tsmc5_models.spice
.include ./netlist.spice

.PARAM supply_voltage = 0.65
.PARAM VCM = 0.0832813
.PARAM PARAM_CLOAD = 5e-10

V1 vdd 0 'supply_voltage'
V2 vss 0 0
Vindc opin 0 'VCM'
.options method=gear maxord=2 cshunt=1e-14 vntol=1e-5
.PARAM GBW_ideal = 1e+06
.PARAM STEP_TIME = '10/GBW_ideal'
* The transient op must settle at the pulse BASELINE, not the common mode:
* seeding vout3 at VCM makes the pre-edge interval a slew event of its own,
* which slew-marginal designs do not survive.
.nodeset V(vout3)=0.0475313

VVISR visr 0 pulse(0.0475313 0.119031 1e-06 1e-09 1e-09 1e-05 0.01)
xop6 vss vdd vout3 visr vout3 leung_dfcfc1_pin_3
CLoad6 vout3 0 'PARAM_CLOAD'

* Search-only diagnostics sample the settled ends of each commanded plateau.
* They do not change the official slew measurements or their crossing windows.
.meas tran v_pre AVG v(vout3) from=5e-07 to=9e-07
.meas tran v_high AVG v(vout3) from=9e-06 to=1.0501e-05
.meas tran v_low AVG v(vout3) from=1.98002e-05 to=2.2e-05

* AnalogGym's fall-edge block names t_fall twice and the second reads a t_fall_
* that never exists, so sr_fall lands 1e6x off sr_rise.  The rise block is the
* correct one and is mirrored here.
.meas tran t_rise_edge when v(vout3)=0.0832813 rise=1 td=1e-06
.meas tran t_rise_ param='t_rise_edge-1e-06'
.meas tran t_rise param='t_rise_*1e6'
.meas tran sr_rise param='0.03575/t_rise'

.meas tran t_fall_edge when v(vout3)=0.0832813 fall=1 td=1.1001e-05
.meas tran t_fall_ param='t_fall_edge-1e-06-1e-05'
.meas tran t_fall param='t_fall_*1e6'
.meas tran sr_fall param='0.03575/t_fall'
.end
