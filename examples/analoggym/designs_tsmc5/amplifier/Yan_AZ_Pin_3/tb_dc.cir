* yan_az_pin_3 -- DC / temperature bench on TSMC5 BSIM-CMG
* Measurements are AnalogGym's TB_Amplifier_ACDC.cir verbatim; supply, common
* mode and load are the TSMC5 design point.
*
* AnalogGym runs all five amplifier instances from one deck.  They share only
* ideal supply rails, so they are electrically independent and splitting them
* changes no measurement -- but five 90 dB loops in one matrix does not solve:
* gmin, source stepping and the transient op all fail, and which groupings
* happen to converge is luck of the Newton basin, not a rule.  One instance per
* deck is the only robust structure.
.include ./tsmc5_models.spice
.include ./netlist.spice

.PARAM supply_voltage = 0.65
.PARAM VCM = 0.1625
.PARAM PARAM_CLOAD = 5e-10

V1 vdd 0 'supply_voltage'
V2 vss 0 0
Vindc opin 0 'VCM'
.nodeset V(vout6)=0.1625

*    DC ALL TB
VVDDdc VDDdc 0 'supply_voltage'
xop5 vss vdddc vout6 opin vout6 yan_az_pin_3
Cload5 vout6 0 'PARAM_CLOAD'

.measure dc maxval MAX V(vout6) from=-40 to=125
.measure dc minval MIN V(vout6) from=-40 to=125
.measure dc avgval AVG V(vout6) from=-40 to=125
.measure dc ppavl  PP V(vout6) from=-40 to=125
.measure dc TC param='ppavl/avgval/165'
* Segment measurements let finalize recover the exact full range with two
* continuation sweeps when a single 165 C sweep loses its Newton branch.
.measure dc max_hot  MAX V(vout6) from=25 to=125
.measure dc min_hot  MIN V(vout6) from=25 to=125
.measure dc avg_hot  AVG V(vout6) from=25 to=125
.measure dc max_cold MAX V(vout6) from=-40 to=25
.measure dc min_cold MIN V(vout6) from=-40 to=25
.measure dc avg_cold AVG V(vout6) from=-40 to=25
.meas dc Ivdd25 FIND I(VVDDDC) AT=25
.meas dc Power param='-1*Ivdd25*supply_voltage'
.meas dc vout25 FIND V(vout6) AT=25
* a .meas param expression cannot read a .PARAM, so VCM is inlined
.meas dc vos25 param = 'vout25-0.1625'
.end
