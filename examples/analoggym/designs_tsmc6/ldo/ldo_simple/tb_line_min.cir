* ldo_simple -- line regulation, min load on TSMC6 BSIM-CMG
* Measurement set is AnalogGym's TB_LDO_ACDC / TB_LDO_Tran.
.include ./tsmc6_models.spice
.include ./netlist.spice

.PARAM supply_voltage = 0.75
.PARAM Vref = 0.5625
.PARAM VOUT_NOM = 0.5625
V2 vss 0 0
Vindc vref_in 0 'Vref'
V1 vdd 0 'supply_voltage'
.nodeset V(vo)=0.5625
x1 vdd vo vref_in vo_vb 0 vo ldo_simple
V1_vb vo_vb 0 0.375
CL vo 0 1e-07
Iload vo 0 0.005
.end
