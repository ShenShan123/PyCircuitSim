* ldo_folded_cascode -- loop response, min load on TSMC6 BSIM-CMG
* Measurement set is AnalogGym's TB_LDO_ACDC / TB_LDO_Tran.
.include ./tsmc6_models.spice
.include ./netlist.spice

.PARAM supply_voltage = 0.75
.PARAM Vref = 0.567187
.PARAM VOUT_NOM = 0.5625
V2 vss 0 0
Vindc vref_in 0 'Vref'
V1 vdd 0 'supply_voltage'
.nodeset V(vo)=0.5625
x1 vdd vo_inp vo_vb2 vref_in vo_vb1 0 vo ldo_folded_cascode
V1_vb2 vo_vb2 0 0.1
V1_vb1 vo_vb1 0 0.45
CL vo 0 1e-07
Iload vo 0 0.005
Vin signal_in 0 dc 'Vref' ac 1
Lfb vo_inp vo 1T
Cfb vo_inp signal_in 1T
.meas ac dcgain_min find vdb(vo) at=0.1
.meas ac gbw_min when vdb(vo)=0
.meas ac ph_rad_min find vp(vo) when vdb(vo)=0
.meas ac pm_min param='abs(ph_rad_min)*180/3.1416'
.end
