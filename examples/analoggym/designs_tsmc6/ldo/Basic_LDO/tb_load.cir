* Basic_LDO -- load regulation / power / offset on TSMC6 BSIM-CMG
* Measurement set is AnalogGym's TB_LDO_ACDC / TB_LDO_Tran.
.include ./tsmc6_models.spice
.include ./netlist.spice

.PARAM supply_voltage = 0.75
.PARAM Vref = 0.28125
.PARAM VOUT_NOM = 0.5625
V2 vss 0 0
Vindc vref_in 0 'Vref'
V1 vdd 0 'supply_voltage'
.nodeset V(vo)=0.5625
x1 0 vdd vref_in vo vo_fb vo_fb vo_ib Basic_LDO
I1_b vo_ib 0 2e-05
CL vo 0 1e-07
Iload vo 0 0.005
.meas dc lr_avg AVG V(vo) from=0.005 to=0.055
.meas dc lr_pp  PP  V(vo) from=0.005 to=0.055
.meas dc lr param='lr_pp/lr_avg/0.05'
.meas dc ivdd_max FIND I(V1) AT=0.055
.meas dc ivdd_min FIND I(V1) AT=0.005
.meas dc power_max param='-1*ivdd_max*0.75'
.meas dc power_min param='-1*ivdd_min*0.75'
.meas dc vout_max FIND V(vo) AT=0.055
.meas dc vout_min FIND V(vo) AT=0.005
.meas dc vos_max param='vout_max-0.5625'
.meas dc vos_min param='vout_min-0.5625'
.end
