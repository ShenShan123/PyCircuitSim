* ptat_4 -- AnalogGym sensing front end on TSMC6 BSIM-CMG
* Topology is the shipped one; geometry is re-designed for 0.75 V.
.subckt ptat_4 GND VDD VOUT
NM9 VDD VOUT VOUT GND nulvt_l120_f6 m=4000
NM8 VDD VOUT VOUT GND nlvt_l90_f6 m=4000
NM7 VOUT VOUT GND GND nsvt_l36_f4 m=48
NM6 VOUT VOUT GND GND nsvt_l36_f6 m=72
NM3 VOUT VOUT GND GND nsvt_l36_f20 m=96
NM2 VDD VOUT VOUT GND nulvt_l36_f2 m=47
NM1 VOUT VOUT GND GND nlvt_l240_f2 m=2
NM0 VDD VOUT VOUT GND nulvt_l120_f6 m=1200
.ends ptat_4
