* Derived three-output subthreshold reference temperature bench
.include ./tsmc6_models.spice
.include ./netlist.spice

.options abstol=1e-16 gmin=1e-15 reltol=1e-4
.nodeset V(vref1)=0.28125 V(vref2)=0.28125 V(vref3)=0.28125

.PARAM supply_voltage = 0.75
Vvdda vdda 0 'supply_voltage'
.measure dc vref1_at25 FIND v(vref1) AT=25
.measure dc vref1_max MAX v(vref1) from=-40 to=125
.measure dc vref1_min MIN v(vref1) from=-40 to=125
.measure dc vref1_pp PP v(vref1) from=-40 to=125
.measure dc vref1_avg AVG v(vref1) from=-40 to=125
.measure dc vref1_tc param='vref1_pp/vref1_avg/165*1e6'
.measure dc vref2_at25 FIND v(vref2) AT=25
.measure dc vref2_max MAX v(vref2) from=-40 to=125
.measure dc vref2_min MIN v(vref2) from=-40 to=125
.measure dc vref2_pp PP v(vref2) from=-40 to=125
.measure dc vref2_avg AVG v(vref2) from=-40 to=125
.measure dc vref2_tc param='vref2_pp/vref2_avg/165*1e6'
.measure dc vref3_at25 FIND v(vref3) AT=25
.measure dc vref3_max MAX v(vref3) from=-40 to=125
.measure dc vref3_min MIN v(vref3) from=-40 to=125
.measure dc vref3_pp PP v(vref3) from=-40 to=125
.measure dc vref3_avg AVG v(vref3) from=-40 to=125
.measure dc vref3_tc param='vref3_pp/vref3_avg/165*1e6'
.end
