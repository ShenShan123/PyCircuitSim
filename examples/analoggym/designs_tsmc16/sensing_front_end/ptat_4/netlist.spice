* ptat_4 -- AnalogGym sensing front end on TSMC16 BSIM-CMG
* Topology is the shipped one; geometry is re-designed for 0.8 V.
.subckt ptat_4 GND VDD VOUT
NM9 VDD VOUT VOUT GND nlvt_l180_f4 m=568
NM8 VDD VOUT VOUT GND nlvt_l90_f20 m=1600
NM7 VOUT VOUT GND GND nlvt_l240_f16 m=8
NM6 VOUT VOUT GND GND nlvt_l36_f20 m=6
NM3 VOUT VOUT GND GND nlvt_l240_f16 m=8
NM2 VDD VOUT VOUT GND nlvt_l180_f4 m=568
NM1 VOUT VOUT GND GND nlvt_l36_f20 m=6
NM0 VDD VOUT VOUT GND nlvt_l90_f20 m=1600
.ends ptat_4
