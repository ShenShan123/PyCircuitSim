* ptat_3 -- AnalogGym sensing front end on TSMC16 BSIM-CMG
* Topology is the shipped one; geometry is re-designed for 0.8 V.
.subckt ptat_3 GND VDD VOUT
NM3 VOUT VOUT GND GND nulvt_l180_f20 m=1
NM2 VDD VOUT VOUT GND nulvt_l120_f20 m=71
NM1 VOUT VOUT GND GND nulvt_l36_f2 m=1
NM0 VDD VOUT VOUT GND nulvt_l240_f10 m=400
.ends ptat_3
