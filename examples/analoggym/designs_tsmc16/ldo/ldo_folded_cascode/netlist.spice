* ldo_folded_cascode -- AnalogGym LDO on TSMC16 BSIM-CMG (LEVEL=72)
* Topology is the shipped one.  Geometry is re-designed for a 0.8 V
* rail, and the mim caps / poly resistors become ideal C and R because
* this TSMC16 view carries transistor models only.
.subckt ldo_folded_cascode Vdd vinp Vb2 vinn Vb1 Vss Vreg
NM10 Vreg vout1 Vdd Vdd plvt_l16_f6 m=1500 $ pass device
NM1 net2 vinp net4 Vss nlvt_l60_f8 m=16
NM2 net3 vinn net4 Vss nlvt_l60_f8 m=16
NM4 net3 net1 Vdd Vdd plvt_l60_f8 m=16
NM3 net2 net1 Vdd Vdd plvt_l60_f8 m=16
NM9 net4 Vb1 Vss Vss nlvt_l60_f8 m=8
NM6 vout1 Vb2 net3 Vdd plvt_l60_f8 m=16
NM5 net1 Vb2 net2 Vdd plvt_l60_f8 m=16
NM7 net1 Vb1 Vss Vss nlvt_l60_f8 m=8
NM8 vout1 Vb1 Vss Vss nlvt_l60_f8 m=8
CCfb net2 Vreg 3e-12   $ was XCfb (mim)
RRfb net2 vout1 43700.7   $ was XRfb (poly)
.ends ldo_folded_cascode
