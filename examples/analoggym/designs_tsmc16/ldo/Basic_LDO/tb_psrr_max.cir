* Basic_LDO -- PSRR, max load on TSMC16 BSIM-CMG
* Measurement set is AnalogGym's TB_LDO_ACDC / TB_LDO_Tran.
.include ./tsmc16_models.spice
.include ./netlist.spice

.PARAM supply_voltage = 0.8
.PARAM Vref = 0.3
.PARAM VOUT_NOM = 0.6
V2 vss 0 0
Vindc vref_in 0 'Vref'
VVDDApsrr vddpsrr 0 'supply_voltage' AC=1
.nodeset V(vp)=0.6
x2 0 vddpsrr vref_in vp vp_fb vp_fb vp_ib Basic_LDO
I2_b vp_ib 0 2e-05
CL2 vp 0 1e-07
Iload2 vp 0 0.055
.meas ac psrr_max find vdb(vp) at=0.1
.end
