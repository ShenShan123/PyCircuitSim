* tan_clia_pin_3 -- common-mode bench on TSMC16 BSIM-CMG
* Measurements are AnalogGym's TB_Amplifier_ACDC.cir verbatim; supply, common
* mode and load are the TSMC16 design point.
*
* AnalogGym runs all five amplifier instances from one deck.  They share only
* ideal supply rails, so they are electrically independent and splitting them
* changes no measurement -- but five 90 dB loops in one matrix does not solve:
* gmin, source stepping and the transient op all fail, and which groupings
* happen to converge is luck of the Newton basin, not a rule.  One instance per
* deck is the only robust structure.
.include ./tsmc16_models.spice
.include ./netlist.spice

.PARAM supply_voltage = 0.8
.PARAM VCM = 0.275
.PARAM PARAM_CLOAD = 5e-10

V1 vdd 0 'supply_voltage'
V2 vss 0 0
Vindc opin 0 'VCM'
* cshunt: 1 fF from every node to ground, far below any device capacitance
* here.  The common-mode deck's operating point fails outright on some
* tech/design pairs (TSMC6 Qu_LEC) without it; measured CMRR is unchanged
* on decks that converge either way.  rshunt is added only to the
* characterized tech/design pairs that need it.
.option cshunt=1e-15 rshunt=1e10
.nodeset V(cm3)=0.275 V(cm2)=0.275

*    ACM TB
xop2 vss vdd cm2 cm1 cm3 tan_clia_pin_3
Cload2 cm3 0 'PARAM_CLOAD'
vcmdc cm0 0 'VCM'
vcmac1 cm1 cm0 0 ac=1
vcmac2 cm2 cm3 0 ac=1

.meas ac cmrrdc find vdb(cm3) at = 0.1
.end
