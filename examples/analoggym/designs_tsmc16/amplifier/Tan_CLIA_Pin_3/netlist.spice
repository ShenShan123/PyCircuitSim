* tan_clia_pin_3 -- AnalogGym topology on TSMC16 BSIM-CMG (LEVEL=72)
* Connectivity and mirror ratios are the shipped ones; geometry is re-designed for 0.8 V FinFET.
.subckt tan_clia_pin_3 gnda vdda vinn vinp vout
Nm73 net5 DM_1 VDDA VDDA psvt_l120_f4 m=24   $ BIASCM_PMOS
Nm70 net3 net050 VDDA VDDA psvt_l140_f6 m=16   $ gm21_PMOS
Nm2 DM_1 DM_1 VDDA VDDA psvt_l120_f4 m=8   $ BIASCM_PMOS
Nm68 VOUT net050 VDDA VDDA psvt_l140_f8 m=32   $ gmf_PMOS
Nm6 net050 VOUTN VDDA VDDA psvt_l120_f4 m=2   $ LOAD1_PMOS
Nm5 VOUTN VOUTN VDDA VDDA psvt_l120_f4 m=2   $ LOAD1_PMOS
Nm9 net8 VINP net31 net31 psvt_l140_f8 m=2   $ gm1_PMOS
Nm8 DM_2 VINN net31 net31 psvt_l140_f8 m=2   $ gm1_PMOS
Nm4 net31 net1 VDDA VDDA psvt_l120_f4 m=16   $ BIASCM_PMOS
Nm3 VB3 net1 VDDA VDDA psvt_l120_f4 m=8   $ BIASCM_PMOS
Nm1 VB4 net1 VDDA VDDA psvt_l120_f4 m=8   $ BIASCM_PMOS
Nm0 net1 net1 VDDA VDDA psvt_l120_f4 m=8   $ BIASCM_PMOS
Nm72 net5 net3 GNDA GNDA nsvt_l140_f6 m=48   $ gm23_NMOS
Nm61 net3 VB4 GNDA GNDA nsvt_l120_f4 m=12   $ BIASCM_NMOS
Nm71 net3 net3 GNDA GNDA nsvt_l140_f6 m=16   $ gm23_NMOS
Nm19 DM_2 VB4 GNDA GNDA nsvt_l120_f4 m=24   $ BIASCM_NMOS
Nm15 VOUTN VB3 DM_2 GNDA nsvt_l120_f4 m=16   $ BIASCM_NMOS
Nm20 net8 VB4 GNDA GNDA nsvt_l120_f4 m=24   $ BIASCM_NMOS
Nm16 net050 VB3 net8 GNDA nsvt_l120_f4 m=16   $ BIASCM_NMOS
Nm18 net7 VB4 GNDA GNDA nsvt_l120_f4 m=8   $ BIASCM_NMOS
Nm12 VB4 VB3 net6 GNDA nsvt_l120_f4 m=8   $ BIASCM_NMOS
Nm13 DM_1 VB3 net7 GNDA nsvt_l120_f4 m=8   $ BIASCM_NMOS
Nm17 net6 VB4 GNDA GNDA nsvt_l120_f4 m=8   $ BIASCM_NMOS
Nm69 VOUT net5 GNDA GNDA nsvt_l86_f12 m=6   $ gm3_NMOS
Nm14 VB3 VB3 GNDA GNDA nsvt_l120_f4 m=2   $ BIASCM_NMOS
I0 net1 GNDA 1.14286e-06
C1 net8 VOUT 1e-12
C0 net2 GNDA 2e-12
R0 net5 net2 20000
.ends tan_clia_pin_3
