* alfio_raffc_pin_3 -- AnalogGym topology on TSMC16 BSIM-CMG (LEVEL=72)
* Connectivity and mirror ratios are the shipped ones; geometry is re-designed for 0.8 V FinFET.
.subckt alfio_raffc_pin_3 gnda vdda vinn vinp vout
Nm11 VOUT net050 VDDA VDDA psvt_l20_f8 m=16   $ gmf_PMOS
Nm7 net043 net013 VDDA VDDA psvt_l36_f12 m=1728   $ gm3_PMOS
Nm10 net013 net050 VDDA VDDA psvt_l20_f8 m=16   $ gm2_PMOS
Nm6 net050 VOUTN VDDA VDDA psvt_l180_f4 m=32   $ BIASCM_PMOS
Nm5 VOUTN VOUTN VDDA VDDA psvt_l180_f4 m=32   $ BIASCM_PMOS
Nm9 net063 VINP net31 net31 psvt_l20_f8 m=1   $ gm1_PMOS
Nm8 DM_2 VINN net31 net31 psvt_l20_f8 m=1   $ gm1_PMOS
Nm4 net31 net1 VDDA VDDA psvt_l180_f4 m=8   $ BIASCM_PMOS
Nm3 VB3 net1 VDDA VDDA psvt_l180_f4 m=4   $ BIASCM_PMOS
Nm2 DM_1 net1 VDDA VDDA psvt_l180_f4 m=4   $ BIASCM_PMOS
Nm1 VB4 net1 VDDA VDDA psvt_l180_f4 m=4   $ BIASCM_PMOS
Nm0 net1 net1 VDDA VDDA psvt_l180_f4 m=4   $ BIASCM_PMOS
Nm59 net013 VB4 GNDA GNDA nsvt_l180_f4 m=32   $ BIASCM_NMOS
Nm22 VOUT net043 GNDA GNDA nsvt_l180_f4 m=4   $ LOAD2_NMOS
Nm21 net043 net043 GNDA GNDA nsvt_l180_f4 m=4   $ LOAD2_NMOS
Nm19 DM_2 VB4 GNDA GNDA nsvt_l180_f4 m=32   $ BIASCM_NMOS
Nm15 VOUTN VB3 DM_2 GNDA nsvt_l20_f6 m=8   $ gmb_NMOS
Nm20 net063 VB4 GNDA GNDA nsvt_l180_f4 m=32   $ BIASCM_NMOS
Nm16 net050 VB3 net063 GNDA nsvt_l20_f6 m=8   $ gmb_NMOS
Nm17 net54 VB4 GNDA GNDA nsvt_l180_f4 m=16   $ BIASCM_NMOS
Nm14 VB3 VB3 GNDA GNDA nsvt_l180_f4 m=4   $ BIASCM_NMOS
Nm12 VB4 VB3 net54 GNDA nsvt_l180_f4 m=16   $ BIASCM_NMOS
Nm18 net56 VB4 GNDA GNDA nsvt_l180_f4 m=16   $ BIASCM_NMOS
Nm13 DM_1 VB3 net56 GNDA nsvt_l180_f4 m=16   $ BIASCM_NMOS
I0 net1 GNDA 1.25e-05
C1 net050 net013 3.57143e-11
C0 net063 VOUT 7.14286e-11
.ends alfio_raffc_pin_3
