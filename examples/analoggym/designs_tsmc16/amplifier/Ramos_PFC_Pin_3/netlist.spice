* ramos_pfc_pin_3 -- AnalogGym topology on TSMC16 BSIM-CMG (LEVEL=72)
* Connectivity and mirror ratios are the shipped ones; geometry is re-designed for 0.8 V FinFET.
.subckt ramos_pfc_pin_3 gnda vdda vinn vinp vout
Nm11 VOUT net050 VDDA VDDA psvt_l96_f3 m=1   $ gmf1_PMOS
Nm7 net049 net1 VDDA VDDA psvt_l240_f12 m=7   $ BIASCM_PMOS
Nm10 net043 net050 VDDA VDDA psvt_l192_f17 m=11   $ gm2_PMOS
Nm6 net050 VOUTN VDDA VDDA psvt_l240_f12 m=7   $ BIASCM_PMOS
Nm5 VOUTN VOUTN VDDA VDDA psvt_l240_f12 m=7   $ BIASCM_PMOS
Nm9 net063 VINP net31 net31 psvt_l120_f16 m=1   $ gm1_PMOS
Nm8 DM_2 VINN net31 net31 psvt_l120_f16 m=1   $ gm1_PMOS
Nm4 net31 net1 VDDA VDDA psvt_l240_f12 m=28   $ BIASCM_PMOS
Nm3 VB3 net1 VDDA VDDA psvt_l240_f12 m=7   $ BIASCM_PMOS
Nm2 DM_1 net1 VDDA VDDA psvt_l240_f12 m=7   $ BIASCM_PMOS
Nm1 VB4 net1 VDDA VDDA psvt_l240_f12 m=7   $ BIASCM_PMOS
Nm0 net1 net1 VDDA VDDA psvt_l240_f12 m=7   $ BIASCM_PMOS
Nm23 VOUT net049 GNDA GNDA nsvt_l106_f5 m=5   $ gm3_NMOS
Nm22 net049 net043 GNDA GNDA nsvt_l90_f5 m=12   $ LOAD2_NMOS
Nm21 net043 net043 GNDA GNDA nsvt_l90_f5 m=12   $ LOAD2_NMOS
Nm19 DM_2 VB4 GNDA GNDA nsvt_l166_f1 m=16   $ BIASCM_NMOS
Nm15 VOUTN VB3 DM_2 GNDA nsvt_l166_f1 m=8   $ BIASCM_NMOS
Nm20 net063 VB4 GNDA GNDA nsvt_l166_f1 m=16   $ BIASCM_NMOS
Nm16 net050 VB3 net063 GNDA nsvt_l166_f1 m=8   $ BIASCM_NMOS
Nm17 net54 VB4 GNDA GNDA nsvt_l166_f1 m=8   $ BIASCM_NMOS
Nm14 VB3 VB3 GNDA GNDA nsvt_l166_f1 m=2   $ BIASCM_NMOS
Nm12 VB4 VB3 net54 GNDA nsvt_l166_f1 m=8   $ BIASCM_NMOS
Nm18 net56 VB4 GNDA GNDA nsvt_l166_f1 m=8   $ BIASCM_NMOS
Nm13 DM_1 VB3 net56 GNDA nsvt_l166_f1 m=8   $ BIASCM_NMOS
I0 net1 GNDA 4.21053e-06
C0 net050 VOUT 4e-12
C1 net050 net049 2.5e-13
.ends ramos_pfc_pin_3
