* qu2017_azc_pin_3 -- AnalogGym topology on TSMC7 BSIM-CMG (LEVEL=72)
* Connectivity and mirror ratios are the shipped ones; geometry is re-designed for 0.75 V FinFET.
.subckt qu2017_azc_pin_3 gnda vdda vinn vinp vout
Nm7 net057 net055 VDDA VDDA psvt_l80_f6 m=12   $ AZC2_PMOS
Nm6 net055 net055 VDDA VDDA psvt_l80_f6 m=6   $ AZC2_PMOS
Nm3 net078 VB1 VDDA VDDA psvt_l240_f4 m=6   $ BIASCM_PMOS
Nm13 VOUT net050 VDDA VDDA psvt_l116_f10 m=3   $ gmf2_PMOS
Nm8 net049 VB1 VDDA VDDA psvt_l240_f4 m=2   $ BIASCM_PMOS
Nm11 net094 net050 VDDA VDDA psvt_l80_f8 m=25   $ gm2_PMOS
Nm5 net050 VOUTN VDDA VDDA psvt_l240_f4 m=1   $ BIASCM_PMOS
Nm4 VOUTN VOUTN VDDA VDDA psvt_l240_f4 m=1   $ BIASCM_PMOS
Nm10 net063 VINP net019 net019 psvt_l80_f8 m=2   $ gm1_PMOS
Nm9 DM_2 VINN net019 net019 psvt_l80_f8 m=2   $ gm1_PMOS
Nm2 net019 VB1 VDDA VDDA psvt_l240_f4 m=2   $ BIASCM_PMOS
Nm1 VB4 VB1 VDDA VDDA psvt_l240_f4 m=1   $ BIASCM_PMOS
Nm0 VB1 VB1 VDDA VDDA psvt_l240_f4 m=1   $ BIASCM_PMOS
Nm24 net049 net057 GNDA GNDA nsvt_l128_f4 m=6   $ AZC3_NMOS
Nm12 net055 net094 GNDA GNDA nsvt_l80_f4 m=6   $ AZC1_NMOS
Nm16 net077 DM_2 GNDA GNDA nsvt_l240_f2 m=1   $ LOAD1_NMOS
Nm17 net082 net063 GNDA GNDA nsvt_l240_f2 m=1   $ LOAD1_NMOS
Nm18 VOUT net049 GNDA GNDA nsvt_l209_f8 m=6   $ gm3_NMOS
Nm22 net094 net051 GNDA GNDA nsvt_l128_f4 m=24   $ AZC3_NMOS
Nm23 net057 net043 GNDA GNDA nsvt_l128_f4 m=18   $ AZC3_NMOS
Nm20 DM_2 VB4 GNDA GNDA nsvt_l150_f4 m=1   $ BIASCM_NMOS
Nm14 VOUTN net077 DM_2 GNDA nsvt_l240_f2 m=1   $ LOAD1_NMOS
Nm21 net063 VB4 GNDA GNDA nsvt_l150_f4 m=1   $ BIASCM_NMOS
Nm15 net050 net082 net063 GNDA nsvt_l240_f2 m=1   $ LOAD1_NMOS
Nm19 VB4 VB4 GNDA GNDA nsvt_l150_f4 m=1   $ BIASCM_NMOS
I0 VB1 GNDA 1.6e-06
C2 net043 GNDA 1e-12
C1 net051 GNDA 2e-12
C0 net063 VOUT 2e-12
R3 net057 net043 20000
R2 net057 net051 20000
R1 net078 net082 20000
R0 net078 net077 20000
.ends qu2017_azc_pin_3
