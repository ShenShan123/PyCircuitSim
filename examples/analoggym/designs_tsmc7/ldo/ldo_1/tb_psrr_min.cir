* ldo_1 -- PSRR, min load on TSMC7 BSIM-CMG
* Measurement set is AnalogGym's TB_LDO_ACDC / TB_LDO_Tran.
.include ./tsmc7_models.spice
.include ./netlist.spice

.PARAM supply_voltage = 0.75
.PARAM Vref = 0.285645
.PARAM VOUT_NOM = 0.5625
V2 vss 0 0
Vindc vref_in 0 'Vref'
VVDDApsrr vddpsrr 0 'supply_voltage' AC=1
.nodeset V(vp)=0.5625
x2 0 vddpsrr vref_in vp vp_fb vp_fb vp_ib ldo_1
I2_b vddpsrr vp_ib 1.35417e-05
CL2 vp 0 1e-07
Iload2 vp 0 0.005
.meas ac psrr_min find vdb(vp) at=0.1
.end
