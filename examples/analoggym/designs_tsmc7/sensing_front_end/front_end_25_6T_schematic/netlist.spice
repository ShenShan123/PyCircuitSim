* front_end_25_6T_schematic -- AnalogGym sensing front end on TSMC7 BSIM-CMG
* Topology is the shipped one; geometry is re-designed for 0.75 V.
.subckt front_end_25_6T_schematic GND VDD VOUT
NM5 VOUT VOUT GND GND nsvt_l240_f3 m=1
NM4 net19 GND GND GND nulvt_l60_f2 m=4
NM3 net13 GND VOUT GND nulvt_l180_f2 m=360
NM2 net13 net13 GND GND nulvt_l240_f2 m=20
NM1 VDD GND net13 GND nlvt_l36_f12 m=1728
NM0 VDD GND net19 GND nsvt_l240_f10 m=27
.ends front_end_25_6T_schematic
