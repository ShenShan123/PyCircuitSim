* ptat_1 -- AnalogGym sensing front end on TSMC7 BSIM-CMG
* Topology is the shipped one; geometry is re-designed for 0.75 V.
.subckt ptat_1 GND VDD VOUT
NM5 VOUT VOUT GND GND nsvt_l36_f4 m=3
NM4 VDD VOUT VOUT GND nlvt_l90_f10 m=21
NM3 VOUT VOUT GND GND nsvt_l36_f4 m=3
NM2 VDD VOUT VOUT GND nlvt_l90_f10 m=7
NM1 VOUT VOUT GND GND nsvt_l36_f2 m=1
NM0 VDD VOUT VOUT GND nlvt_l90_f20 m=7
.ends ptat_1
