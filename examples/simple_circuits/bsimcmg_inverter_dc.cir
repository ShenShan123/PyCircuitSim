* BSIM-CMG CMOS inverter voltage-transfer curve — LEVEL=72 reference
.include "<BAKED_NMOS>"
.include "<BAKED_PMOS>"
Vdd vdd 0 <VDD>
Vin in 0 0
Nn out in 0 0 <NMOS>
Np out in vdd vdd <PMOS>
.temp <TEMP>
<ANALYSIS>
.end
