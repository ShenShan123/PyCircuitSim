* Transmission-gate hold and feedthrough — LEVEL=72 reference
.include "<BAKED_LIB>"
Vdd vdd 0 <VDD>
Vbn bn 0 <BODY_N>
Vbp bp 0 <BODY_P>
Vin vin 0 <HALF_VDD>
Vphi phi 0 PULSE(<VDD> 0 1n 20p 20p 2n 4n)
Vphib phib 0 PULSE(0 <VDD> 1n 20p 20p 2n 4n)
Nn_tg hold phi vin bn <NMOS>
Np_tg hold phib vin bp <PMOS>
Chold hold 0 100f
.ic V(hold)=<HALF_VDD>
.temp <TEMP>
<ANALYSIS>
.end
