* Two-stage Miller opamp — NGSPICE BSIM-CMG (LEVEL=72) ground truth
*
* The reference half of the opamp gate. `tests/verify_complex_opamp.py`
* renders this deck per technology and scores the DirectNet result in
* `directnet_opamp_miller_dc.sp` against it. Ground truth is ALWAYS NGSPICE on
* the identical BSIM-CMG OSDI model — never a simplified or self-defined
* equation (AGENTS.md Validation rule).
*
* <TOKEN> placeholders are substituted by tests.common.base
* :: render_reference_deck. <BAKED_LIB> is the merged NMOS+PMOS modelcard with
* L / NFIN / TFIN / DEVTYPE baked in (NGSPICE cannot set those per instance on
* an OSDI device). OSDI devices take the N prefix, not M.
*
* Bias rails are fractions of VDD: Vcm 0.55, Vbn 0.45, Vbp 0.55. The .dc
* window is Vcm +/- 0.15 V at 2 mV, supplied by the runner.

.include "<BAKED_LIB>"
.temp 27

Vdd  vdd 0 <VDD>
Vbn  vbn 0 <VBN>
Vbp  vbp 0 <VBP>
Vinn inn 0 <VCM>
Vinp inp 0 <VCM>

* --- stage 1: NMOS diff pair + PMOS mirror load + NMOS tail ---
Nn1 n1    inp vtail 0   <NMOS>
Nn2 vo1i  inn vtail 0   <NMOS>
Np3 n1    n1  vdd   vdd <PMOS>
Np4 vo1i  n1  vdd   vdd <PMOS>
Nn5 vtail vbn 0     0   <NMOS>

* --- stage 2: CS PMOS gain stage + NMOS current-source load ---
Np6 vout vo1i vdd vdd <PMOS>
Nn7 vout vbn  0   0   <NMOS>

* --- Miller compensation + load ---
Cc vo1i vout 20f
CL vout 0 50f

.end
