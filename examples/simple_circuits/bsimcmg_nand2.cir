* Two-input static CMOS NAND — LEVEL=72 reference
.include "<BAKED_LIB>"
Vdd vdd 0 <VDD>
Vbn bn 0 <BODY_N>
Vbp bp 0 <BODY_P>
Va a 0 <VA_SPEC>
Vb b 0 <VB_SPEC>
Np_a out a vdd bp <PMOS>
Np_b out b vdd bp <PMOS>
Nn_a out a nint bn <NMOS>
Nn_b nint b 0 bn <NMOS>
Cload out 0 5f
.ic V(out)=<VDD> V(nint)=0
.temp <TEMP>
<ANALYSIS>
.end
