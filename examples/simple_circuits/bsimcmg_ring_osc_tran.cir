* Odd-stage CMOS ring oscillator — NGSPICE BSIM-CMG (LEVEL=72) ground truth
*
* The reference half of the ring-oscillator gate.
* `tests/simple_circuits/verify_circuit_ring_osc.py` renders this deck per technology and
* scores the oscillation period of `directnet_ring_osc_tran.sp` against it.
* Ground truth is ALWAYS NGSPICE on the identical BSIM-CMG OSDI model
* (AGENTS.md Validation rule).
*
* <TOKEN> placeholders are substituted by tests.common.base
* :: render_reference_deck. <BAKED_LIB> is the merged modelcard with
* L / NFIN / TFIN / DEVTYPE baked in. OSDI devices take the N prefix.
*
* Five stages, 0.5 fF per node. The .tran statement is supplied by the runner.
* The shared renderer expands the same stage block for 3/5/7/9-stage sweeps;
* verify_circuit_sweep_canaries.py checks candidate/reference topology parity.

.include "<BAKED_LIB>"
.temp <TEMP>

Vdd vdd 0 <VDD>

<RING_STAGES>

* An alternating seed kicks the loop off its unstable DC point.
.ic <RING_IC>

<ANALYSIS>
.end
