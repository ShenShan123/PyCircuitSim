* 6T SRAM read-SNM half-cell — NGSPICE BSIM-CMG (LEVEL=72) ground truth
*
* The reference half of the SRAM static-noise-margin gate.
* `tests/verify_complex_sram_snm.py` renders this deck per technology and per
* fin count, and scores the DirectNet butterfly lobe in
* `directnet_sram_snm_dc.sp` against it point-by-point. Ground truth is ALWAYS
* NGSPICE on the identical BSIM-CMG OSDI model (CLAUDE.md Validation rule).
*
* <TOKEN> placeholders are substituted by tests.common.base
* :: render_reference_deck. <BAKED_LIB> is the merged modelcard with
* L / NFIN / TFIN / DEVTYPE baked in — the fin count reaches the devices
* through that bake, which is why NFIN appears nowhere in this deck. OSDI
* devices take the N prefix.
*
* The read-SNM butterfly is a pair of voltage-transfer curves of the two half
* cells under read bias. This is one of them: the cross-coupled feedback is
* broken and the storage node q is driven, while qb is read. The mirror lobe
* is the same deck with q and qb swapped, which the harness gets by
* reflecting the curve rather than by simulating a second time.
*
* Read bias: word line asserted, bit line precharged high. The .dc statement
* (sweep Vq 0 -> VDD at 5 mV) is supplied by the runner.

.include "<BAKED_LIB>"
.temp 27

Vdd vdd 0 <VDD>
Vwl wl  0 <VDD>
Vbl bl  0 <VDD>
Vq  q   0 0.0

* --- storage inverter q -> qb ---
Npl qb q vdd vdd <PMOS>
Nnl qb q 0   0   <NMOS>

* --- access transistor bl <-> qb, gated by the word line ---
Nna bl wl qb 0 <NMOS>

.end
