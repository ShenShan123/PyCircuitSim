* Complementary common-gate stages — LEVEL=72 reference
.include "<BAKED_LIB>"
Vdd vdd 0 <VDD>
Vgn gn 0 <GATE_N>
Vgp gp 0 <GATE_P>
Vsn sn 0 0
Vsp sp 0 <VDD>
Vbn bn 0 <BODY_N>
Vbp bp 0 <BODY_P>
Rn vdd dn 12k
Nn_cg dn gn sn bn <NMOS>
Rp dp 0 12k
Np_cg dp gp sp bp <PMOS>
.temp <TEMP>
<ANALYSIS>
.end
