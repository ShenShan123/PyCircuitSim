* Bidirectional CMOS transmission gate — LEVEL=72 reference
.include "<BAKED_LIB>"
Vdd vdd 0 <VDD>
Vbn bn 0 <BODY_N>
Vbp bp 0 <BODY_P>
Vphi phi 0 <VDD>
Vphib phib 0 0
Vinf inf 0 0
Nn_f outf phi inf bn <NMOS>
Np_f outf phib inf bp <PMOS>
Rf outf 0 10k
Vrev outr 0 0
Nn_r inr phi outr bn <NMOS>
Np_r inr phib outr bp <PMOS>
Rr inr 0 10k
.temp <TEMP>
<ANALYSIS>
.end
