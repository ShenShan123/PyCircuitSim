* Two-input static CMOS NOR — LEVEL=72 reference
.include "<BAKED_LIB>"
Vdd vdd 0 <VDD>
Vbn bn 0 <BODY_N>
Vbp bp 0 <BODY_P>
Va a 0 <VA_SPEC>
Vb b 0 <VB_SPEC>
Np_a pint a vdd bp <PMOS>
Np_b out b pint bp <PMOS>
Nn_a out a 0 bn <NMOS>
Nn_b out b 0 bn <NMOS>
Cload out 0 5f
.ic V(out)=<VDD> V(pint)=<VDD>
.temp <TEMP>
<ANALYSIS>
.end
