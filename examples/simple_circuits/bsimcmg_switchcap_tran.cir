* Switched-capacitor unit cell — NGSPICE BSIM-CMG (LEVEL=72) ground truth
*
* The reference half of the switched-cap gate.
* `tests/simple_circuits/verify_circuit_switchcap.py` renders this deck per technology and
* scores the NN candidate in `directnet_switchcap_tran.sp` against its
* charge-transfer level and hold droop. Ground truth is ALWAYS NGSPICE on
* the identical BSIM-CMG OSDI model (AGENTS.md Validation rule).
*
* <TOKEN> placeholders are substituted by tests.common.base
* renderer. <BAKED_LIB> is the merged modelcard with
* L / NFIN / TFIN / DEVTYPE baked in. OSDI devices take the N prefix, and
* NGSPICE wants the parenthesised PULSE syntax (PyCircuitSim takes it
* space-separated — the two decks differ there on purpose).
*
* Clock: 4 ns period, 1.9 ns sample phase, 0.1 ns edges, 0.5 ns delay. The
* .tran statement is supplied by the runner.

.include "<BAKED_LIB>"
.temp <TEMP>

Vdd  vdd 0 <VDD>
Vin  vin 0 <VIN>
Vphi phi 0 PULSE(0 <VDD> <TD> <SLEW> <SLEW> <PW> <PER>)

* --- clock inverter: phi -> phib ---
Npc phib phi vdd vdd <PMOS>
Nnc phib phi 0   0   <NMOS>

* --- CMOS transmission gate: vin <-> vsamp ---
Nnt vin phi  vsamp 0   <NMOS>
Npt vin phib vsamp vdd <PMOS>

Csample vsamp 0 <CSAMPLE>

.ic v(vsamp)=0 v(phib)=<VDD>

<ANALYSIS>
.end
