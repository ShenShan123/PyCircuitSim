* BSIM-CMG CMOS inverter pulse response — LEVEL=72 reference
.include "<BAKED_NMOS>"
.include "<BAKED_PMOS>"
Vdd vdd 0 <VDD>
Vin in 0 PULSE(0 <VDD> <TD> <TR> <TF> <PW> <PER>)
Nn out in 0 0 <NMOS>
Np out in vdd vdd <PMOS>
Cload out 0 <CLOAD>
.ic V(out)=<VDD>
.temp <TEMP>
<ANALYSIS>
.end
