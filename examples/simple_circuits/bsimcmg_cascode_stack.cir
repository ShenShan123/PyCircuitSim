* Complementary cascode compliance and AC gain branches — LEVEL=72 reference
.include "<BAKED_LIB>"
Vdd vdd 0 <VDD>
Vbn bn 0 <BODY_N>
Vbp bp 0 <BODY_P>
Vbiasn biasn 0 <BIAS_N>
Vcasn casn 0 <CAS_N>
Voutn dn 0 0
Nn_lo nx biasn 0 bn <NMOS>
Nn_hi dn casn nx bn <NMOS>
Vbiasp biasp 0 <BIAS_P>
Vcasp casp 0 <CAS_P>
Voutp dp 0 <VDD>
Np_lo px biasp vdd bp <PMOS>
Np_hi dp casp px bp <PMOS>
Vinac inac 0 dc <BIAS_N> ac 1
Rna vdd nac 20k
Nn_alo nax inac 0 bn <NMOS>
Nn_ahi nac casn nax bn <NMOS>
Vipac ipac 0 dc <BIAS_P> ac 1
Rpa pac 0 20k
Np_alo pax ipac vdd bp <PMOS>
Np_ahi pac casp pax bp <PMOS>
.temp <TEMP>
<ANALYSIS>
.end
