* CMOS inverter operating point — NGSPICE BSIM-CMG (LEVEL=72) ground truth
*
* The reference half of the inverter-OP gate. Scored against
* `bsimcmg_inverter_op.sp`. Ground truth is ALWAYS NGSPICE on the identical
* BSIM-CMG OSDI model (CLAUDE.md Validation rule).
*
* <TOKEN> placeholders are substituted by tests.common.base
* :: render_reference_deck. <COMBINED_LIB> is a single modelcard with BOTH
* nmos_rvt and pmos_rvt baked to bsimcmg type carrying L / NFIN / DEVTYPE —
* it has to be one file, because including two separately-baked cards leaves
* each one re-declaring the other model as an unparseable `level=72`.
*
* OSDI devices take the N prefix, not M.

.include "<COMBINED_LIB>"
.temp 27

Vdd vdd 0 <VDD>
Vin in 0 <VIN>

Np out in vdd vdd pmos_rvt
Nn out in 0 0 nmos_rvt

.op

.end
