* BSIM-CMG common-source amplifier AC — NGSPICE ground truth
*
* The reference half of the AC gate's Level 2
* (`tests/simple_circuits/verify_ac.py`), scored against
* `bsimcmg_cs_amp_ac.sp`. Ground truth is ALWAYS NGSPICE on the identical
* BSIM-CMG OSDI model (CLAUDE.md Validation rule).
*
* <TOKEN> placeholders are substituted by tests.common.base
* :: render_reference_deck. <BAKED_LIB> is the merged NMOS+PMOS modelcard with
* L / NFIN / TFIN / DEVTYPE baked in — NGSPICE cannot set those per instance
* on an OSDI device, which is why no geometry appears on the instance line
* here while the PyCircuitSim half carries it explicitly. OSDI devices take
* the N prefix, not M.
*
* The bias (<VBIAS>) puts the device in saturation at mid-rail, so the low-
* frequency gain is -gm*(RD||ro) and the roll-off is the Miller (Cgd)
* feedback plus the RD/Cload output pole — the device capacitances ARE the
* measurement. Bulk ties to source (0) so the source-referenced small-signal
* capacitance matrix is exact.

.include "<BAKED_LIB>"
.temp 27

VDD vdd 0 <VDD>
Vin in 0 dc <VBIAS> ac 1
RD vdd out <RD>
Nn1 out in 0 0 <NMOS>
Cload out 0 <CLOAD>

.end
