* RC low-pass AC — NGSPICE ground truth
*
* The reference half of the AC gate's Level 1
* (`tests/simple_circuits/verify_ac.py`), scored against `rc_lowpass_ac.sp`
* and against the closed form H(jw) = 1/(1 + jwRC) — the one place in the
* suite where an analytic answer is admissible, because the circuit is purely
* linear and passive and no compact model is involved.
*
* R = 1k, C = 159.155 nF  ->  fc = 1 / (2*pi*R*C) = 1000 Hz exactly.
*
* No <TOKEN>s: nothing here varies per technology. The `.ac` card is supplied
* by the runner. NGSPICE spells the source stimulus `dc 0 ac 1`, which is the
* only line that differs from the PyCircuitSim half.

V1 in 0 dc 0 ac 1
R1 in out 1k
C1 out 0 159.155n

.end
