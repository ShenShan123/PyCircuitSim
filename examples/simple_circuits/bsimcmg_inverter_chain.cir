* Open fanout-of-four inverter chain — LEVEL=72 reference
.include "<BAKED_LIB>"
Vdd vdd 0 <VDD>
Vbn bn 0 <BODY_N>
Vbp bp 0 <BODY_P>
Vin in 0 PULSE(0 <VDD> 0.5n 20p 20p 1n 2n)
Np_drv n1 in vdd bp <PMOS>
Nn_drv n1 in 0 bn <NMOS>
Np_l0 o0 n1 vdd bp <PMOS>
Nn_l0 o0 n1 0 bn <NMOS>
Np_l1 o1 n1 vdd bp <PMOS>
Nn_l1 o1 n1 0 bn <NMOS>
Np_l2 o2 n1 vdd bp <PMOS>
Nn_l2 o2 n1 0 bn <NMOS>
Np_l3 o3 n1 vdd bp <PMOS>
Nn_l3 o3 n1 0 bn <NMOS>
C0 o0 0 2f
C1 o1 0 2f
C2 o2 0 2f
C3 o3 0 2f
.ic V(n1)=<VDD> V(o0)=0 V(o1)=0 V(o2)=0 V(o3)=0
.temp <TEMP>
<ANALYSIS>
.end
